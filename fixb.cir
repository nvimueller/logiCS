.include models/90nm.pm

.param volt = 1.0
.param pl   = 90n
.param nl   = 90n
.param pw   = 360n
.param nw   = 180n

vdd vdd 0 dc {volt}

va ga 0 pulse(0 {volt} 1n 10p 10p 2n 4n)
vb gb 0 dc {volt}

.subckt nand2 a b out vdd vss
    mpa out a vdd vdd pmos w={pw} l={pl}
    mpb out b vdd vdd pmos w={pw} l={pl}
    mna out a mid vss nmos w={nw} l={nl}
    mnb mid b vss vss nmos w={nw} l={nl}
.ends nand2

xone ga gb out vdd 0 nand2
cload out 0 5f

.control
    tran 10p 5n
    plot v(ga) v(out)+1.5
    meas tran tphl_alh trig v(ga) val=0.5 rise=1 targ v(out) val=0.5 fall=1 >/dev/null
    meas tran tplh_ahl trig v(ga) val=0.5 fall=1 targ v(out) val=0.5 rise=1 >/dev/null
    let tphl_alh = tphl_alh * 1e12
    let tplh_ahl = tplh_ahl * 1e12
    echo "tphl_alh  = $&tphl_alh ps"
    echo "tplh_ahl  = $&tplh_ahl ps"
.endc

.end
